** Profile: "SCHEMATIC1-Resposta temporal"  [ C:\Users\j.mendez.orero\Desktop\Practica1\practica1-pspicefiles\schematic1\resposta temporal.sim ]

** Creating circuit file "Resposta temporal.cir"
** WARNING: THIS AUTOMATICALLY GENERATED FILE MAY BE OVERWRITTEN BY SUBSEQUENT SIMULATIONS

*Libraries:
* Profile Libraries :
* Local Libraries :
* From [PSPICE NETLIST] section of C:\Cadence\SPB_16.5\tools\PSpice\PSpice.ini file:
.lib "nom.lib"

*Analysis directives:
.TRAN  0 15us  0 75us
.PROBE V(alias(*)) I(alias(*)) W(alias(*)) D(alias(*)) NOISE(alias(*))
.INC "..\SCHEMATIC1.net"

.END
